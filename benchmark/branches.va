//Test item:contribution stmt
`include "disciplines.vams"
`include "constants.vams"

module branches(anode, gate, cathode, nsat);
	inout anode, gate, cathode, nsat;
	electrical anode, gate, cathode, nsat, qceb,mucinv;
	electrical drain, emitter;
	electrical dvdgdt, dvbcdt;

        branch (gate, cathode)	gate_cathode;	// define a branch
        branch (drain, cathode) drain_cathode1;
        real vdg,vgs,vds,vae,ved,qcgs,qcdsj,imult,imos,icdg,ibp,ic,rb,vebj,nsat1,mucinv1;
        parameter real cgs=1e-13 from (0:inf);
        parameter real cgd=1e-13 from (0:inf);

	analog begin
            @(initial_step) begin
            ibp = 1e-12;
            rb = 1.0;
            imult = 1.0;
            end
		vdg = V(drain, gate);
		vgs = V(gate, cathode);
		vds = V(drain, cathode);
		vae = V(anode, emitter);
		ved = V(emitter, drain);

                qcgs = cgs*vgs;
                icdg = cgd*V(dvdgdt);

		I(anode, emitter) <+ vae/rb+I(gate_cathode);
		I(gate_cathode) <+ ddt(qcgs);
		I(drain, gate) <+ icdg;
		I(drain_cathode1) <+ imos + imult + cgs*ddt(qcdsj);
		I(emitter, cathode) <+ ic;
		I(emitter, drain) <+ ibp + ddt(V(qceb));
		//I(emitter, drain) <+ ddt(ibp*icdg + V(qceb));

		V(dvdgdt,emitter) <+ ddt(vdg);
		V(dvbcdt) <+ ved+ddt(vds);
		//V(dvbcdt) <+ ddt(vds);
		//V(qceb) <+ vebj - ved;
		V(qceb) <+ V(qceb) - vebj + ved;
		V(nsat,mucinv) <+ nsat1/(I(drain_cathode1));
		//V(nsat,mucinv) <+ nsat1/ddt(I(drain_cathode1));
		V(mucinv) <+ mucinv1;
	end

endmodule
