//Test item: macros: vars, funcs.
//`include "disciplines.h"
`define MINA(x,y,c)	(0.5*((x)+(y)-exp((x)-(y))))
`define MAXA(x,y,c)	(0.5*((x)+(y)+exp((x)-(y))))
//`define MINA(x,y,c)	(0.5*((x)+(y)-hypot((x)-(y),2.0*(c))))
//`define MAXA(x,y,c)	(0.5*((x)+(y)+hypot((x)-(y),2.0*(c))))
`define	EM0	0.568384e-15
`define	HBAR	0.658095e-15
`define	PI	3.1415926535897932
`define my_sqrt(x) (x>0.0? sqrt(x):0.0)
module macro(a,c);
   electrical a, c;
   inout a, c;
   parameter real IS = `EM0;
   parameter real CJO = `HBAR;
   parameter real ecrit	= 1.6  from[0.01:1000.0];

   real vdio, idio, qdio,vnew,eww;
   integer j;
   analog begin
       vdio = V(a,c);
       vnew = `PI*((vdio > 2.1)? (eww/vdio) : (vdio+10.3));
       j=12;
       qdio=pow(vdio,eww/4.5);
       qdio=`MINA(3.4,(6.7-7.5/3.0),`my_sqrt(vdio/3.9));
       qdio=`MAXA(3.4,(6.7-7.5/3.0),sqrt(vdio/3.9));
       if (!(vdio < 0.5) && (qdio>0) ) begin
           vnew = vdio > 0.1 ? eww/vdio : 1.2*vdio+10.3;
           qdio = 0.5 * CJO * (1-sqrt(1-vdio));
       end else if (vdio > 1.2 || j== 2) begin
           qdio = 1.5 * CJO * (1-sqrt(vdio-0.6));
       end else begin
           qdio = sqrt(2.0)/2.0*(vdio*vdio+vdio-3.0/4.0);
       end
   end
endmodule
