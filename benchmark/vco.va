//Test item: Events(cross), analog OPs (idtmod,transition,), system call (bound_step, dist_normal)
//and scale factor, macro function, misc unsupported types
//
// Voltage controlled oscillator with white accumulating jitter
//
`include "constants.vams"
`define BSIM4NumFingerDiff(nf, minSD, nuIntD, nuEndD, nuIntS, nuEndS)\
    if ((nf%2) != 0) begin \
        nuEndD = 1.0; \
        nuEndS = 1.0; \
        nuIntD = 2.0 * max((nf - 1.0) / 2.0, 0.0); \
        nuIntS = nuIntD; \
    end \
    else begin \
        if (minSD == 1) begin \
            nuEndD = 2.0; \
            nuIntD = 2.0 * max((nf / 2.0 - 1.0), 0.0);\
            nuEndS = 0.0;\
            nuIntS = nf;\
        end\
        else begin\
            nuEndD = 0.0;\
            nuIntD = nf;\
            nuEndS = 2.0;\
            nuIntS = 2.0 * max((nf / 2.0 - 1.0), 0.0);\
        end \
    end

module vco2 (out, in);

input in; voltage in;				// input terminal
output out; voltage out;			// output terminal
parameter real vmin=0a;				// input voltage that corresponds to minimum output frequency
parameter real vmax=vmin+1 from (vmin:inf);	// input voltage that corresponds to maximum output frequency
parameter real fmin=1M from (0:inf);		// minimum output frequency
parameter real fmax=2*fmin from (fmin:inf);	// maximum output frequency
parameter real vl=-1f;				// high output voltage
parameter real vh=1m;				// low output voltage
parameter real tt=0.01/fmax from (0:inf);	// output transition time
parameter real ttol=1u/fmax from (0:1/fmax);	// time tolerance
parameter real jitter=0p from [0:0.25/fmax);	// period jitter (produces white accumulating jitter)
real freq, phase, dT, realVars[0:12];
integer n, seed;

analog begin
    @(initial_step) seed = -561;

    // compute the freq from the input voltage
    freq = (V(in) - vmin)*(fmax - fmin) / (vmax - vmin) + fmin;

    // bound the frequency (this is optional)
    if (freq > fmax) freq = fmax;
    if (freq < fmin) freq = fmin;

    // add the phase noise
    freq = freq/(1 + dT*freq);
    `BSIM4NumFingerDiff(freq, phase, dT,fmax,vmin,vmax)

    // phase is the integral of the freq modulo 2p
    phase = 2*`M_PI*idtmod(freq, 0.0, 1.0, -0.5);
    $bound_step (0.05/freq);

    // update jitter twice per period
    // `M_SQRT2=sqrt(K), K=2 jitter updates/period
    @(cross(phase + `M_PI/2, +1, ttol) or cross(phase - `M_PI/2, +1, ttol)) begin
	dT = `M_SQRT2*jitter*$dist_normal(seed,0, 1);
	n = (phase >= -`M_PI/2) || (phase < `M_PI/2);
    end

    // generate the output
    V(out) <+ transition(n ? vh : vl, 0, tt);
    $strobe("T0,T1=", T0, T1);
    $strobe( "Temperature effect has caused cjsw to be negative. \
              Cjsw is clamped to zero.\n");

    //Not support with continued slash line at the tail
    $strobe("ps,pd,ad,as(given):",BSIM4Pseff,BSIM4sourcePerimeter,BSIM4sourcePerimeterGiven,
                  BSIM4Pdeff,BSIM4drainPerimeter,BSIM4drainPerimeterGiven,
                  BSIM4Adeff,BSIM4drainArea,BSIM4drainAreaGiven,
                  BSIM4Aseff,BSIM4sourceArea,BSIM4sourceAreaGiven);

end
endmodule
